* CMOS inverter, minimum-area design
.include "D:\AUC\Uni\Fall 25\Microelectronics\Project\Saif and adham\CMOS 0.18\MOSFET_models_0p5_0p18-3.inc"
* supply sources
VDD no1 0 1.8V
VG no2 0 0
* MOSFETs
Mpmos no3 no2 no1 no1 PMOS0P18 l=0.18u w=0.9u ad=0.486p as=0.486p pd=2.88u ps=2.88u
Mnmos no3 no2 0 0 NMOS0P18 l=0.18u w=0.9u ad=0.486p as=0.486p pd=2.88u ps=2.88u
* Resistor and Capacitor
Rr1 no3 no4 1k
Cc1 no4 0 0.2p
* DC sweep
.DC VG 0 1.8V 1m
.END
